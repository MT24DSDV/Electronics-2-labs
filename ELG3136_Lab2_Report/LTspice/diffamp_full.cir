* ELG3136 Lab 2: differential amplifier of Figure 7, three copies in one run
*   copy d: differential mode, RS = 76k so vd ~ 20 mVpp   -> Ad, Ads, Rid, phase
*   copy c: common mode, Q2's capacitor moved to B        -> Acm, CMRR
*   copy l: large input (300 mVpp at the base)            -> linear range of the output
*
* Bench-matched devices:
*   QP1/QP2 give beta ~156 / ~147 at VCE ~ 10 V (your measured Q1/Q2)
*   Q4 area 1.28 stands for the ~6 mV VBE mismatch between the two discrete mirror
*   transistors, so the tail current comes out ~1.87 mA like the bench.
*   Set the 1.28 to 1 to simulate the nominal design instead.
* Note: 2Meg, not 2M (2M means 2 milliohm in SPICE).

VCC  vcc 0 10
VEE  vee 0 -10
* 200 mVpp, 5 kHz source (High Z)
VS   s   0 SINE(0 0.1 5k)
* 300 mVpp source for the linear-range copy
VL   sl  0 SINE(0 0.15 5k)

* ---------- copy d: differential mode ----------
RSd  s    xd   76k
C1d  xd   b1d  10u
RB1d vcc  b1d  2Meg
RB2d vcc  b2d  2Meg
* Q2 base AC-grounded (point A)
C2d  b2d  0    10u
RC1d vcc  c1d  2.2k
RC2d vcc  c2d  2.2k
Q1d  c1d  b1d  ed  QP1
Q2d  c2d  b2d  ed  QP2
RKd  0    kd   6.8k
Q3d  kd   kd   vee QM
Q4d  ed   kd   vee QM 1.28

* ---------- copy c: common mode ----------
C1c  s    b1c  10u
RB1c vcc  b1c  2Meg
RB2c vcc  b2c  2Meg
* Q2 base tied to B through its capacitor
C2c  b2c  b1c  10u
RC1c vcc  c1c  2.2k
RC2c vcc  c2c  2.2k
Q1c  c1c  b1c  ec  QP1
Q2c  c2c  b2c  ec  QP2
RKc  0    kc   6.8k
Q3c  kc   kc   vee QM
Q4c  ec   kc   vee QM 1.28

* ---------- copy l: linear range ----------
C1l  sl   b1l  10u
RB1l vcc  b1l  2Meg
RB2l vcc  b2l  2Meg
C2l  b2l  0    10u
RC1l vcc  c1l  2.2k
RC2l vcc  c2l  2.2k
Q1l  c1l  b1l  el  QP1
Q2l  c2l  b2l  el  QP2
RKl  0    kl   6.8k
Q3l  kl   kl   vee QM
Q4l  el   kl   vee QM 1.28

.model QP1 NPN(IS=6.734e-15 BF=137 VAF=74)
.model QP2 NPN(IS=6.734e-15 BF=129 VAF=74)
.model QM  NPN(IS=6.734e-15 BF=150 VAF=74)

.tran 0 3m 0 0.2u
.options plotwinsize=0 numdgt=15 reltol=1e-6

* ---------- DC operating point (copy d at t = 0) ----------
.meas TRAN VC1   FIND V(c1d)  AT=0
.meas TRAN VC2   FIND V(c2d)  AT=0
.meas TRAN VB1   FIND V(b1d)  AT=0
.meas TRAN VB2   FIND V(b2d)  AT=0
.meas TRAN VE    FIND V(ed)   AT=0
.meas TRAN IT    FIND Ic(Q4d) AT=0
.meas TRAN Voff  PARAM VC1-VC2

* ---------- differential mode ----------
.meas TRAN vs_pp   PP V(s)            FROM=1m TO=3m
.meas TRAN vd_pp   PP V(b1d)          FROM=1m TO=3m
.meas TRAN vo1_pp  PP V(c1d)          FROM=1m TO=3m
.meas TRAN vod_pp  PP V(c1d)-V(c2d)   FROM=1m TO=3m
.meas TRAN Ad      PARAM vod_pp/vd_pp
.meas TRAN Ad_se   PARAM vo1_pp/vd_pp
.meas TRAN Ads     PARAM vod_pp/vs_pp
* 76e3 below must equal RSd
.meas TRAN Rp      PARAM 76e3*vd_pp/(vs_pp-vd_pp)
.meas TRAN Rid     PARAM Rp*2e6/(2e6-Rp)

* ---------- common mode ----------
.meas TRAN vcm_pp  PP V(b1c)          FROM=1m TO=3m
.meas TRAN vo1c_pp PP V(c1c)          FROM=1m TO=3m
.meas TRAN vodc_pp PP V(c1c)-V(c2c)   FROM=1m TO=3m
.meas TRAN Acm_se  PARAM vo1c_pp/vcm_pp
.meas TRAN Acm_d   PARAM vodc_pp/vcm_pp
.meas TRAN CMRR_se PARAM 20*log10(Ad_se/Acm_se)
.meas TRAN CMRR_d  PARAM 20*log10(Ad/Acm_d)

* ---------- linear range ----------
.meas TRAN vc1_max MAX V(c1l)          FROM=1m TO=3m
.meas TRAN vc1_min MIN V(c1l)          FROM=1m TO=3m
.meas TRAN vod_max MAX V(c1l)-V(c2l)   FROM=1m TO=3m
.meas TRAN vod_min MIN V(c1l)-V(c2l)   FROM=1m TO=3m
.end
